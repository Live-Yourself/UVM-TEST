************************************************************************
* auCdl Netlist:
*
* Library Name:  PMT064_TPlay
* Top Cell Name: BUFX4_ESD_7T
* View Name:     schematic
* Netlisted on:  Oct 23 16:10:23 2019
************************************************************************

*.EQUATION
*.SCALE METER
*.MEGA
.PARAM

************************************************************************
* Library Name: PMT064_TPlay
* Cell Name:    BUFX4_ESD_7T
* View Name:    schematic
************************************************************************

.SUBCKT BUFX4_ESD_7T A VDD VSS Y
*.PININFO A:I Y:O VDD:B VSS:B
MNM0 net11 net06 VSS VSS n18 W=680n L=180n m=1
MNM1 net06 VSS VSS VSS n18 W=3u L=200n m=1
MM1 Y net11 VSS VSS n18 W=880n L=180n m=2
MPM0 net11 net06 VDD VDD p18 W=980n L=180n m=1
MM0 Y net11 VDD VDD p18 W=1.32u L=180n m=2
RR1 A net06 206.189 $[rnposab] $W=2.3u $L=1u M=1
.ENDS
